# Ansys Electronics Desktop project, version 2022.2
materials:
  vacuum: permittivity=1
  copper: permeability=0.999991 conductivity=58000000
  air: permittivity=1.0006 permeability=1.0000004

design Maxwell3DDesign1 (Maxwell 3D, EddyCurrent, model units mm)
variables:
  gapdist = 100mm
  i = 50A
  misal = 0mm
geometry:
  Tx [copper] = user_primitive(SegmentedHelix/PolygonHelix.dll, PolygonSegments=0, PolygonRadius=1mm, StartHelixRadius=120mm, RadiusChange=2.1mm, Pitch=0mm, Turns=10, SegmentsPerTurn=36, RightHanded=1)
  Polyline1 = polyline(xyz in mm: (119.54336, 0, 0) (119.54336, -15, 3) (200, -20, 3), section circle width=2mm)
  Polyline2 = polyline(z=0mm, xy in mm: (140.46345, 0.0025420426) (140.46345, 16) (200, 20), section circle width=2mm)
  Region [air] = box(corner=(-150mm, -160mm, -40mm), size=(330mm, 530mm, 200mm))
  Tx.unite(Polyline1, Polyline2)
  Box2 = box(corner=(180mm, -160mm, 20mm), size=(40mm, 320mm, -40mm))
  Tx.subtract(Box2)
  Rx [copper] = user_primitive(SegmentedHelix/PolygonHelix.dll, PolygonSegments=0, PolygonRadius=1mm, StartHelixRadius=120mm, RadiusChange=2.1mm, Pitch=0mm, Turns=10, SegmentsPerTurn=36, RightHanded=1)
  Polyline3 = polyline(xyz in mm: (119.54336, 0, 0) (119.54336, -15, 3) (200, -20, 3), section circle width=2mm)
  Polyline4 = polyline(z=0mm, xy in mm: (140.46345, 0.0025420426) (140.46345, 16) (200, 20), section circle width=2mm)
  Rx.unite(Polyline3, Polyline4)
  Box3 = box(corner=(180mm, -160mm, 20mm), size=(40mm, 320mm, -40mm))
  Rx.subtract(Box3)
  Rx.move(0mm, 0mm, gapdist)
  Rx.move(0mm, misal, 0mm)
  Circle1 [non-model] = circle(normal=Z, centre=(0mm, 0mm, 100mm), radius=180mm)
  Circle2 [non-model] = circle(normal=Z, centre=(0mm, 0mm, 0mm), radius=161.24515mm)
boundaries and excitations:
  Tx_I_in: Current Faces=Tx.face(at (180, -18.7571, 3)) Phase=0deg Current=i IsSolid=false Point_out_of_terminal=false
  Tx_I_out: Current Faces=Tx.face(at (180, 18.6563, 0)) Phase=0deg Current=i IsSolid=false Point_out_of_terminal=true
  Rx_I_in: Current Faces=Rx.face(#7487) Phase=0deg Current=0A IsSolid=true Point_out_of_terminal=false
  Rx_I_out: Current Faces=Rx.face(#7488) Phase=0deg Current=0A IsSolid=true Point_out_of_terminal=true
parameters:
  Matrix1: Matrix Rx_I_in, Tx_I_in:
mesh:
  Region: LengthBased RefineInside Objects=Region MaxLength=100mm
  Coil: LengthBased Objects=[Rx, Tx] MaxLength=80mm
  initial mesh: GlobalSurfApproximation{CurvedSurfaceApproxChoice=UseSlider SliderMeshSettings=1} GlobalCurvilinear{Apply}
setups:
  Setup1: EddyCurrent MaximumPasses=10 MinimumPasses=2 MinimumConvergedPasses=1 PercentRefinement=30 PercentError=10 RelativeResidual=1e-05 NonLinearResidual=0.0001 Frequency=85kHz SweepRanges{80kHz to 100kHz step 1kHz} SaveAllFields
optimetrics:
  ParametricSetup1: Parametric Sim._Setups=[Setup1]
    sweep misal: LIN 0mm 200mm 50mm
reports:
  Coupling Coeff Table 1: Matrix1.CplCoef(Rx_I_in,Rx_I_in), Matrix1.CplCoef(Tx_I_in,Rx_I_in), Matrix1.CplCoef(Rx_I_in,Tx_I_in), Matrix1.CplCoef(Tx_I_in,Tx_I_in) vs misal on Setup1 : LastAdaptive [misal=0mm Freq=all]
  L Plot 1: Matrix1.L(Rx_I_in,Rx_I_in), Matrix1.L(Tx_I_in,Rx_I_in), Matrix1.L(Rx_I_in,Tx_I_in), Matrix1.L(Tx_I_in,Tx_I_in) vs misal on Setup1 : LastAdaptive [misal=0mm Freq=all]
  Coupling Coeff Plot 1: Matrix1.CplCoef(Rx_I_in,Rx_I_in), Matrix1.CplCoef(Tx_I_in,Rx_I_in), Matrix1.CplCoef(Rx_I_in,Tx_I_in), Matrix1.CplCoef(Tx_I_in,Tx_I_in) vs misal on Setup1 : LastAdaptive [misal=0mm Freq=all]
  L Table 1: Matrix1.L(Rx_I_in,Rx_I_in), Matrix1.L(Tx_I_in,Rx_I_in), Matrix1.L(Rx_I_in,Tx_I_in), Matrix1.L(Tx_I_in,Tx_I_in) vs misal on Setup1 : LastAdaptive [misal=0mm Freq=all]

design Simplorer1 (Twin Builder)
variables:
  f = 85kHz
  Cp = 194nF
  Cs = 990nF
  R_load = 10ohm
components:
  E1 = E(Type=ESINE AMPL=311.12698V FREQ=f PERIO=0 TPERIO=Tend+1)
  I_in = AM()
  Cp = C(C=Cp)
  Mx_SS1 = MaxwellData(ComponentDataType=MaxwellData name=MaxwellData filename="$PROJECTDIR\Circular Coil.aedt" numberofports=4 CouplingDesignName=Maxwell3DDesign1 CouplingSolutionName="Setup1 : LastAdaptive" CouplingMatrixName=Matrix1 CouplingType=SparamMaxwell3DLink VariationKey="gapdist='100mm' i='50A' misal='0mm'" ModelText='// BEGIN ANSOFT HEADER / // node Rx_I_in_src Rx_I_in_src / // node Tx_I_in_src Tx_I_in_src / // node Rx_I_in_snk Rx_I_in_snk / // node Tx_I_in_snk Tx_I_in_snk / // Format: Simplorer SML / // Topckt: MaxwellData_5 / // Date: Mon Feb 13 13:20:29 2023 / // Notes: Frequency range: 80000 to 85000 Hz, 2 points / // : [Frequency] 8.0000000000000000e+04 / // : [Frequency] 8.5000000000000000e+04 / // : Maximum number of poles: 10000 / // : S-Matrix fitting error tolerance: 0.005 / // : Causality check tolerance: 0.01 / // : Passivity enforcement: on (by iterated fitting) / // : Causality enforcement: off / // : Fitting method: FastFit / // : Matrix fitting: By entire matrix (required by FastFit) / // : Ensure Z-parameter accuracy: on / // : Relative error control: off / // : Common ground option: on / // : Final fitting error: 0.0384389 / // : Final model order: 8 / // END ANSOFT HEADER / SMLDEF MaxwellData_5 / { / PORT electrical: Rx_I_in_src ; / PORT electrical: Tx_I_in_src ; / PORT electrical: Rx_I_in_snk ; / PORT electrical: Tx_I_in_snk ; / INTERN SStateSpaceModel MaxwellData_5 \ / N0:=Rx_I_in_src, N1:=Tx_I_in_src, N2:=Rx_I_in_snk, N3:=Tx_I_in_snk \ / ( RefType:=0, NumStates:=8,)
  V_in = VM()
  gnd1 = gnd()
  Cs = C(C=Cs)
  V_out = VM()
  I_out = AM()
  R_load = R(R=R_load)
  gnd2 = gnd()
nets:
  net_1: Mx_SS1.1, V_in.0, Cp.1
  net_2: I_in.0, Cp.0
  net_3: E1.1, I_in.1
  net_4: E1.0, gnd1.0, Mx_SS1.Tx_I_in_src, V_in.1
  net_5: Mx_SS1.0, Cs.1, V_out.0
  net_6: Cs.0, I_out.1
  net_7: R_load.0, I_out.0
  net_8: gnd2.0, Mx_SS1.Rx_I_in_src, R_load.1, V_out.1
setups:
  AC: LinearFrequencyData(1, 80kHz, 100kHz, 1kHz)
  TR: TransientData(40ms, 10.0us, 1.0ms, false, "")
optimetrics:
  ParametricSetup1: Parametric SaveSolutions Sim._Setups=[AC]
    sweep Mx_SS1.misal: LIN 0mm 200mm 50mm
reports:
  XY Plot 1: (mag(V_out.V)*mag(I_out.I)) / (mag(V_in.V)*mag(I_in.I)) vs Mx_SS1.misal on AC : AC [f=all Cp=all Cs=all R_load=all Freq=all]
  Data Table 1: (mag(V_out.V)*mag(I_out.I)) / (mag(V_in.V)*mag(I_in.I)) vs Mx_SS1.misal on AC : AC [f=all Cp=all Cs=all R_load=all Freq=all]
