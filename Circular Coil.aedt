# Ansys Electronics Desktop project, version 2022.2
materials:
  vacuum: permittivity=1
  copper: permeability=0.999991 conductivity=58000000
  air: permittivity=1.0006 permeability=1.0000004

design Maxwell3DDesign1 (Maxwell 3D, EddyCurrent, model units mm)
variables:
  gapdist = 100mm
  i = 50A
  misal = 0mm
geometry:
  Tx [copper] = user_primitive(SegmentedHelix/PolygonHelix.dll, PolygonSegments=0, PolygonRadius=1mm, StartHelixRadius=120mm, RadiusChange=2.1mm, Pitch=0mm, Turns=10, SegmentsPerTurn=36, RightHanded=1)
  Polyline1 = polyline(xyz in mm: (119.54336, 0, 0) (119.54336, -15, 3) (200, -20, 3), section circle width=2mm)
  Polyline2 = polyline(z=0mm, xy in mm: (140.46345, 0.0025420426) (140.46345, 16) (200, 20), section circle width=2mm)
  Region [air] = box(corner=(-150mm, -160mm, -40mm), size=(330mm, 530mm, 200mm))
  Tx.unite(Polyline1, Polyline2)
  Box2 = box(corner=(180mm, -160mm, 20mm), size=(40mm, 320mm, -40mm))
  Tx.subtract(Box2)
  Rx [copper] = user_primitive(SegmentedHelix/PolygonHelix.dll, PolygonSegments=0, PolygonRadius=1mm, StartHelixRadius=120mm, RadiusChange=2.1mm, Pitch=0mm, Turns=10, SegmentsPerTurn=36, RightHanded=1)
  Polyline3 = polyline(xyz in mm: (119.54336, 0, 0) (119.54336, -15, 3) (200, -20, 3), section circle width=2mm)
  Polyline4 = polyline(z=0mm, xy in mm: (140.46345, 0.0025420426) (140.46345, 16) (200, 20), section circle width=2mm)
  Rx.unite(Polyline3, Polyline4)
  Box3 = box(corner=(180mm, -160mm, 20mm), size=(40mm, 320mm, -40mm))
  Rx.subtract(Box3)
  Rx.move(0mm, 0mm, gapdist)
  Rx.move(0mm, misal, 0mm)
  Circle1 [non-model] = circle(normal=Z, centre=(0mm, 0mm, 100mm), radius=180mm)
  Circle2 [non-model] = circle(normal=Z, centre=(0mm, 0mm, 0mm), radius=161.24515mm)
boundaries and excitations:
  Tx_I_in: Current Faces=Tx.face(at (180, -18.7571, 3)) Phase=0deg Current=i IsSolid=false Point_out_of_terminal=false
  Tx_I_out: Current Faces=Tx.face(at (180, 18.6563, 0)) Phase=0deg Current=i IsSolid=false Point_out_of_terminal=true
  Rx_I_in: Current Faces=Rx.face(#7487) Phase=0deg Current=0A IsSolid=true Point_out_of_terminal=false
  Rx_I_out: Current Faces=Rx.face(#7488) Phase=0deg Current=0A IsSolid=true Point_out_of_terminal=true
parameters:
  Matrix1: Matrix Rx_I_in, Tx_I_in:
mesh:
  Region: LengthBased RefineInside Objects=Region MaxLength=100mm
  Coil: LengthBased Objects=[Rx, Tx] MaxLength=80mm
  initial mesh: GlobalSurfApproximation{CurvedSurfaceApproxChoice=UseSlider SliderMeshSettings=1} GlobalCurvilinear{Apply}
setups:
  Setup1: EddyCurrent MaximumPasses=10 MinimumPasses=2 MinimumConvergedPasses=1 PercentRefinement=30 PercentError=10 RelativeResidual=1e-05 NonLinearResidual=0.0001 Frequency=85kHz
reports:
  Coupling Coeff Table 1: Matrix1.CplCoef(Rx_I_in,Rx_I_in), Matrix1.CplCoef(Tx_I_in,Rx_I_in), Matrix1.CplCoef(Rx_I_in,Tx_I_in), Matrix1.CplCoef(Tx_I_in,Tx_I_in) vs misal on Setup1 : LastAdaptive [misal=0mm Freq=all]
  L Plot 1: Matrix1.L(Rx_I_in,Rx_I_in), Matrix1.L(Tx_I_in,Rx_I_in), Matrix1.L(Rx_I_in,Tx_I_in), Matrix1.L(Tx_I_in,Tx_I_in) vs misal on Setup1 : LastAdaptive [misal=0mm Freq=all]
  Coupling Coeff Plot 1: Matrix1.CplCoef(Rx_I_in,Rx_I_in), Matrix1.CplCoef(Tx_I_in,Rx_I_in), Matrix1.CplCoef(Rx_I_in,Tx_I_in), Matrix1.CplCoef(Tx_I_in,Tx_I_in) vs misal on Setup1 : LastAdaptive [misal=0mm Freq=all]
  L Table 1: Matrix1.L(Rx_I_in,Rx_I_in), Matrix1.L(Tx_I_in,Rx_I_in), Matrix1.L(Rx_I_in,Tx_I_in), Matrix1.L(Tx_I_in,Tx_I_in) vs misal on Setup1 : LastAdaptive [misal=0mm Freq=all]

design Simplorer1 (Twin Builder)
variables:
  f = 85kHz
  Cp = 194nF
  Cs = 990nF
  R_load = 10ohm
components:
  E1 = E(Type=ESINE AMPL=311.12698V FREQ=f PERIO=0 TPERIO=Tend+1)
  I_in = AM()
  Cp = C(C=Cp)
  Mx_SS1 = MaxwellData(ComponentDataType=MaxwellData name=MaxwellData filename="$PROJECTDIR\Circular Coil.aedt" numberofports=4 CouplingDesignName=Maxwell3DDesign1 CouplingSolutionName="Setup1 : LastAdaptive" CouplingMatrixName=Matrix1 CouplingType=SparamMaxwell3DLink MaxNumPoles=10000 ErrTol=0.005 SSZref=50ohm Mw2DDepth=1meter MwScale=1 RefPinStyle=3 MxModelType=5 Properties{paramProp(gapdist, 100mm) paramProp(i, 50A) paramProp(misal, 0mm)} PortInfo{OnePortInfo(Rx_I_in_src, -1, Rx_I_in:src) OnePortInfo(Tx_I_in_src, -1, Tx_I_in:src) OnePortInfo(Rx_I_in_snk, -1, Rx_I_in:snk) OnePortInfo(Tx_I_in_snk, -1, Tx_I_in:snk)} misal=0mm)
  V_in = VM()
  gnd1 = gnd()
  Cs = C(C=Cs)
  V_out = VM()
  I_out = AM()
  R_load = R(R=R_load)
nets:
  net_1: V_in.0, Mx_SS1.1, Cp.1
  net_2: I_in.0, Cp.0
  net_3: E1.1, I_in.1
  net_4: E1.0, V_in.1, Mx_SS1.Tx_I_in_src, gnd1.0
  net_5: Mx_SS1.0, Cs.1, V_out.0
  net_6: Cs.0, I_out.1
  net_7: I_out.0, R_load.0
  net_8: Mx_SS1.Rx_I_in_src, V_out.1, R_load.1
