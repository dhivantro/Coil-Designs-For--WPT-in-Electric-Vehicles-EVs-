# Ansys Electronics Desktop project, version 2022.2
materials:
  vacuum: permittivity=1
  copper litz: permeability=0.999991 conductivity=58000000 stacking_type="Litz Wire" wire_type=Round strand_number=1 wire_diameter=2mm
  air: permittivity=1.0006 permeability=1.0000004
  ferrite: permittivity=12 permeability=1000 conductivity=0.01
  aluminum: permeability=1.000021 conductivity=38000000

design Maxwell3DDesign1 (Maxwell 3D, EddyCurrent, model units mm)
variables:
  airgap = 100mm
  misal = 0mm
  i = 50A
geometry:
  Dcoil_Tx [copper litz] = polyline(z=0mm, xy in mm: (140, 60) (140, 0) (0, 0) (0, 140) (136, 140) (136, 4) (4, 4) (4, 136) (132, 136) (132, 8) (8, 8) (8, 132) (128, 132) (128, 12) (12, 12) (12, 128) (124, 128) (124, 16) (16, 16) (16, 124) (120, 124) (120, 20) (20, 20) (20, 120) (116, 120) (116, 24) (24, 24) (24, 116) (112, 116) (112, 28) (28, 28) (28, 112) (108, 112) (108, 32) (32, 32) (32, 108) (104, 108) (104, 36) (36, 36) (36, 104), section circle width=2mm)
  Polyline2 = polyline(y=104mm, xz in mm: (36, 0) (36, 4) (1000, 4), section circle width=2mm)
  Polyline3 = polyline(z=0mm, xy in mm: (140, 60) (140, 70) (1000, 70), section circle width=2mm)
  Dcoil_Tx.unite(Polyline2, Polyline3)
  Box2 = box(corner=(300mm, -50mm, 50mm), size=(800mm, 200mm, -200mm))
  Dcoil_Tx.subtract(Box2)
  Dcoil_Tx1 [copper litz] = polyline(z=0mm, xy in mm: (140, 60) (140, 0) (0, 0) (0, 140) (136, 140) (136, 4) (4, 4) (4, 136) (132, 136) (132, 8) (8, 8) (8, 132) (128, 132) (128, 12) (12, 12) (12, 128) (124, 128) (124, 16) (16, 16) (16, 124) (120, 124) (120, 20) (20, 20) (20, 120) (116, 120) (116, 24) (24, 24) (24, 116) (112, 116) (112, 28) (28, 28) (28, 112) (108, 112) (108, 32) (32, 32) (32, 108) (104, 108) (104, 36) (36, 36) (36, 104), section circle width=2mm)
  Polyline4 = polyline(y=104mm, xz in mm: (36, 0) (36, 4) (1000, 4), section circle width=2mm)
  Polyline5 = polyline(z=0mm, xy in mm: (140, 60) (140, 70) (1000, 70), section circle width=2mm)
  Dcoil_Tx1.unite(Polyline4, Polyline5)
  Box3 = box(corner=(300mm, -50mm, 50mm), size=(800mm, 200mm, -200mm))
  Dcoil_Tx1.subtract(Box3)
  Dcoil_Tx1.move(0mm, 148mm, 0mm)
  Boundary [air] = box(corner=(-30mm, -60mm, 128mm), size=(320mm, 580mm, -157mm))
  Box5 = box(corner=(290mm, -60mm, 40mm), size=(230mm, 380mm, -140mm))
  Dcoil_Tx.subtract(Box5)
  Dcoil_Rx [copper litz] = polyline(z=0mm, xy in mm: (140, 60) (140, 0) (0, 0) (0, 140) (136, 140) (136, 4) (4, 4) (4, 136) (132, 136) (132, 8) (8, 8) (8, 132) (128, 132) (128, 12) (12, 12) (12, 128) (124, 128) (124, 16) (16, 16) (16, 124) (120, 124) (120, 20) (20, 20) (20, 120) (116, 120) (116, 24) (24, 24) (24, 116) (112, 116) (112, 28) (28, 28) (28, 112) (108, 112) (108, 32) (32, 32) (32, 108) (104, 108) (104, 36) (36, 36) (36, 104), section circle width=2mm)
  Polyline6 = polyline(y=104mm, xz in mm: (36, 0) (36, 4) (1000, 4), section circle width=2mm)
  Polyline7 = polyline(z=0mm, xy in mm: (140, 60) (140, 70) (1000, 70), section circle width=2mm)
  Dcoil_Rx.unite(Polyline6, Polyline7)
  Box6 = box(corner=(300mm, -50mm, 50mm), size=(800mm, 200mm, -200mm))
  Dcoil_Rx.subtract(Box6)
  Box8 = box(corner=(290mm, -60mm, 40mm), size=(230mm, 380mm, -140mm))
  Dcoil_Rx.subtract(Box8)
  Dcoil_Rx.move(0mm, 0mm, airgap)
  Dcoil_Rx.move(0mm, misal, 0mm)
  Dcoil_Rx1 [copper litz] = polyline(z=0mm, xy in mm: (140, 60) (140, 0) (0, 0) (0, 140) (136, 140) (136, 4) (4, 4) (4, 136) (132, 136) (132, 8) (8, 8) (8, 132) (128, 132) (128, 12) (12, 12) (12, 128) (124, 128) (124, 16) (16, 16) (16, 124) (120, 124) (120, 20) (20, 20) (20, 120) (116, 120) (116, 24) (24, 24) (24, 116) (112, 116) (112, 28) (28, 28) (28, 112) (108, 112) (108, 32) (32, 32) (32, 108) (104, 108) (104, 36) (36, 36) (36, 104), section circle width=2mm)
  Polyline8 = polyline(y=104mm, xz in mm: (36, 0) (36, 4) (1000, 4), section circle width=2mm)
  Polyline9 = polyline(z=0mm, xy in mm: (140, 60) (140, 70) (1000, 70), section circle width=2mm)
  Dcoil_Rx1.unite(Polyline8, Polyline9)
  Box9 = box(corner=(300mm, -50mm, 50mm), size=(800mm, 200mm, -200mm))
  Dcoil_Rx1.subtract(Box9)
  Dcoil_Rx1.move(0mm, 148mm, 100mm)
  Box10 = box(corner=(290mm, -60mm, 120mm), size=(290mm, 580mm, -140mm))
  Dcoil_Tx1.subtract(Box10)
  Box11 = box(corner=(290mm, -60mm, 120mm), size=(260mm, 580mm, -140mm))
  Dcoil_Rx1.subtract(Box11)
  Dcoil_Rx1.move(0mm, misal, 0mm)
  Circular_Tx [copper litz] = user_primitive(SegmentedHelix/PolygonHelix.dll, PolygonSegments=0, PolygonRadius=1mm, StartHelixRadius=60mm, RadiusChange=2.1mm, Pitch=0mm, Turns=10, SegmentsPerTurn=36, RightHanded=1)
  Circular_Tx.move(65mm, 140mm, -8mm)
  Polyline10 = polyline(z=-8mm, xy in mm: (145.69177, 140.00254) (145, 153) (500, 153), section circle width=2mm)
  Polyline11 = polyline(xyz in mm: (124.77167, 140, -8) (120, 146, -5) (500, 146, -5), section circle width=2mm)
  Circular_Tx.unite(Polyline10, Polyline11)
  Box12 = box(corner=(290mm, -60mm, 120mm), size=(710mm, 580mm, -140mm))
  Circular_Tx.subtract(Box12)
  Circular_Rx [copper litz] = user_primitive(SegmentedHelix/PolygonHelix.dll, PolygonSegments=0, PolygonRadius=1mm, StartHelixRadius=60mm, RadiusChange=2.1mm, Pitch=0mm, Turns=10, SegmentsPerTurn=36, RightHanded=1)
  Circular_Rx.move(65mm, 140mm, -8mm)
  Polyline12 = polyline(z=-8mm, xy in mm: (145.69177, 140.00254) (145, 153) (500, 153), section circle width=2mm)
  Polyline13 = polyline(xyz in mm: (124.77167, 140, -8) (120, 146, -5) (500, 146, -5), section circle width=2mm)
  Circular_Rx.unite(Polyline12, Polyline13)
  Box13 = box(corner=(290mm, -60mm, 120mm), size=(710mm, 580mm, -140mm))
  Circular_Rx.subtract(Box13)
  Circular_Rx.move(0mm, 0mm, 115mm)
  Ferrite_Tx [ferrite] = box(corner=(-10mm, -10mm, -17mm), size=(155mm, 305mm, 5mm))
  Aluminum_Tx [aluminum] = box(corner=(-15mm, -13mm, -24mm), size=(165mm, 312mm, 5mm))
  Aluminum_Rx [aluminum] = box(corner=(-15mm, -13mm, -24mm), size=(165mm, 312mm, 5mm))
  Aluminum_Rx.move(0mm, 0mm, 142mm)
  Ferrite_Rx [ferrite] = box(corner=(-10mm, -10mm, -17mm), size=(155mm, 305mm, 5mm))
  Ferrite_Rx.move(0mm, 0mm, 129mm)
  [Aluminum_Rx, Ferrite_Rx, Circular_Rx].move(0mm, misal, 0mm)
boundaries and excitations:
  Tx_in1: Current Faces=Dcoil_Tx.face(at (290, 70, 0)) Phase=0deg Current=i IsSolid=false Point_out_of_terminal=false
  Tx_out1: Current Faces=Dcoil_Tx.face(at (290, 104, 4)) Phase=0deg Current=i IsSolid=false Point_out_of_terminal=true
  Rx_in1: Current Faces=Dcoil_Rx.face(#2166) Phase=0deg Current=0mA IsSolid=true Point_out_of_terminal=false
  Rx_out1: Current Faces=Dcoil_Rx.face(#2165) Phase=0deg Current=0mA IsSolid=true Point_out_of_terminal=true
  Rx_in2: Current Faces=Dcoil_Rx1.face(#2510) Phase=0deg Current=0mA IsSolid=true Point_out_of_terminal=false
  Rx_out2: Current Faces=Dcoil_Rx1.face(#2509) Phase=0deg Current=0mA IsSolid=true Point_out_of_terminal=true
  Tx_in2: Current Faces=Dcoil_Tx1.face(at (290, 218, 0)) Phase=0deg Current=i IsSolid=false Point_out_of_terminal=false
  Tx_out2: Current Faces=Dcoil_Tx1.face(at (290, 252, 4)) Phase=0deg Current=i IsSolid=false Point_out_of_terminal=true
  Rx_in3: Current Faces=Circular_Rx.face(#6269) Phase=0deg Current=0mA IsSolid=true Point_out_of_terminal=false
  Rx_out3: Current Faces=Circular_Rx.face(#6268) Phase=0deg Current=0mA IsSolid=true Point_out_of_terminal=true
  Tx_in3: Current Faces=Circular_Tx.face(at (290, 146, -5)) Phase=0deg Current=i IsSolid=false Point_out_of_terminal=false
  Tx_out3: Current Faces=Circular_Tx.face(at (290, 153, -8)) Phase=0deg Current=i IsSolid=false Point_out_of_terminal=true
parameters:
  Matrix1: Matrix Rx_in1, Tx_in1, Rx_in2, Tx_in2, Rx_in3, Tx_in3:
mesh:
  Length1: LengthBased RefineInside Objects=Boundary MaxLength=116mm
  Length2: LengthBased Objects=[Aluminum_Rx, Aluminum_Tx, Circular_Rx, Circular_Tx, Dcoil_Rx, Dcoil_Rx1, Dcoil_Tx, Dcoil_Tx1, Ferrite_Rx, Ferrite_Tx] MaxLength=62.4mm
  initial mesh: GlobalSurfApproximation{CurvedSurfaceApproxChoice=UseSlider SliderMeshSettings=1} GlobalCurvilinear{Apply}
setups:
  Setup1: EddyCurrent MaximumPasses=10 MinimumPasses=2 MinimumConvergedPasses=1 PercentRefinement=30 PercentError=20 RelativeResidual=1e-05 NonLinearResidual=0.0001 Frequency=85kHz SweepRanges{80kHz to 100kHz step 1kHz} SaveAllFields
optimetrics:
  ParametricSetup1: Parametric Sim._Setups=[Setup1]
    sweep misal: LIN 0mm 200mm 50mm
reports:
  Coupling Coeff Plot 1: Matrix1.CplCoef(Rx_in1,Rx_in1) vs misal on Setup1 : LastAdaptive [Freq=all]
  Coupling Coeff Table 1: Matrix1.CplCoef(Rx_in1,Rx_in1) vs misal on Setup1 : LastAdaptive [Freq=all]
  L Table 1: Matrix1.L(Rx_in1,Rx_in1) vs misal on Setup1 : LastAdaptive [Freq=all]
  L Plot 1: Matrix1.L(Rx_in1,Rx_in1) vs misal on Setup1 : LastAdaptive [Freq=all]

design Simplorer1 (Twin Builder)
variables:
  f = 85kHz
  R_load = 10ohm
  Cp = 194nF
  Cs = 990nF
components:
  E_source = E(Type=ESINE AMPL=311.12698V FREQ=f PERIO=0 TPERIO=Tend+1)
  Cp = C(C=Cp)
  Cs = C(C=Cs)
  I_in = AM()
  V_in = VM()
  V_out = VM()
  I_out = AM()
  R_load = R(R=R_load)
  gnd1 = gnd()
  gnd2 = gnd()
  Mx_SS1 = MaxwellData7(ComponentDataType=MaxwellData name=MaxwellData7 filename="$PROJECTDIR\Multilayer with ferrite.aedt" numberofports=12 CouplingDesignName=Maxwell3DDesign1 CouplingSolutionName="Setup1 : LastAdaptive" CouplingMatrixName=Matrix1 CouplingType=SparamMaxwell3DLink VariationKey="airgap='100mm' i='50A' misal='0mm'" MaxNumPoles=10000 ErrTol=0.005 SSZref=50ohm Mw2DDepth=1meter MwScale=1 RefPinStyle=3 MxModelType=5 Properties{paramProp(airgap, 100mm) paramProp(i, 50A) paramProp(misal, 0mm)} PortInfo{OnePortInfo(Rx_in1_src, -1, Rx_in1:src) OnePortInfo(Rx_in2_src, -1, Rx_in2:src) OnePortInfo(Rx_in3_src, -1, Rx_in3:src) OnePortInfo(Tx_in1_src, -1, Tx_in1:src) OnePortInfo(Tx_in2_src, -1, Tx_in2:src) OnePortInfo(Tx_in3_src, -1, Tx_in3:src) OnePortInfo(Rx_in1_snk, -1, Rx_in1:snk) OnePortInfo(Rx_in2_snk, -1, Rx_in2:snk) OnePortInfo(Rx_in3_snk, -1, Rx_in3:snk) OnePortInfo(Tx_in1_snk, -1, Tx_in1:snk) OnePortInfo(Tx_in2_snk, -1, Tx_in2:snk) OnePortInfo(Tx_in3_snk, -1, Tx_in3:snk)} misal=0mm)
nets:
  net_1: E_source.1, I_in.1
  net_10: R_load.1, V_out.1, Mx_SS1.6, Mx_SS1.7, Mx_SS1.8, gnd1.0
  net_11: V_in.0, Cp.0, Mx_SS1.3, Mx_SS1.4, Mx_SS1.5
  net_13: V_in.1, E_source.0, gnd2.0, Mx_SS1.9, Mx_SS1.10, Mx_SS1.11
  net_2: I_in.0, Cp.1
  net_7: Cs.0, V_out.0, Mx_SS1.0, Mx_SS1.1, Mx_SS1.2
  net_8: Cs.1, I_out.1
  net_9: R_load.0, I_out.0
setups:
  AC: LinearFrequencyData(1, 80kHz, 100kHz, 1kHz)
optimetrics:
  ParametricSetup1: Parametric SaveSolutions Sim._Setups=[AC]
    sweep Mx_SS1.misal: LIN 0mm 200mm 50mm
reports:
  Data Table 1: (mag(V_out.V)*mag(I_out.I))/(mag(V_in.V)*mag(I_in.I)) vs Mx_SS1.misal on AC : AC [f=all R_load=all Cp=all Cs=all Freq=all]
  XY Plot 1: (mag(V_out.V)*mag(I_out.I))/(mag(V_in.V)*mag(I_in.I)) vs Mx_SS1.misal on AC : AC [f=all R_load=all Cp=all Cs=all Freq=all]
