# Ansys Electronics Desktop project, version 2022.2
materials:
  vacuum: permittivity=1
  copper: permeability=0.999991 conductivity=58000000
  air: permittivity=1.0006 permeability=1.0000004
  ferrite: permittivity=12 permeability=1000 conductivity=0.01
  copper litz: permeability=0.999991 conductivity=58000000 stacking_type="Litz Wire" wire_type=Round strand_number=1
  aluminum: permeability=1.000021 conductivity=38000000

design Maxwell3DDesign1 (Maxwell 3D, EddyCurrent, model units mm)
variables:
  gapdist = 100mm
  i = 50A
  misal = 0mm
geometry:
  Tx [copper litz] = user_primitive(SegmentedHelix/PolygonHelix.dll, PolygonSegments=0, PolygonRadius=1mm, StartHelixRadius=120mm, RadiusChange=2.1mm, Pitch=0mm, Turns=10, SegmentsPerTurn=36, RightHanded=1)
  Region [air] = box(corner=(-200mm, -200mm, -40mm), size=(400mm, 600mm, 200mm))
  Box2 = box(corner=(180mm, -160mm, 20mm), size=(40mm, 320mm, -40mm))
  Tx.subtract(Box2)
  Tx_Fer [ferrite] = cylinder(axis=Z, base_centre=(0mm, 0mm, -2mm), radius=158.11388mm, height=-3mm)
  Rx_Fer [ferrite] = cylinder(axis=Z, base_centre=(0mm, 0mm, 108mm), radius=158.11388mm, height=-3mm)
  Tx_Al [aluminum] = cylinder(axis=Z, base_centre=(0mm, 0mm, -6mm), radius=180.27756mm, height=-4mm)
  Rx_Al [aluminum] = cylinder(axis=Z, base_centre=(0mm, 0mm, 114mm), radius=180.27756mm, height=-4mm)
  [Rx_Al, Rx_Fer].move(0mm, misal, 0mm)
  Box4 = box(corner=(200mm, -200mm, 160mm), size=(400mm, 600mm, -200mm))
  Tx.subtract(Box4)
  Polyline1 = polyline(xyz in mm: (119.54336, 0, 0) (118.5, -7, 3) (300.5, -7, 3), section circle width=2mm)
  Polyline2 = polyline(z=0mm, xy in mm: (140.46345, 0.0025420426) (141, 9) (300, 9), section circle width=2mm)
  Tx.unite(Polyline1, Polyline2)
  Rx [copper litz] = user_primitive(SegmentedHelix/PolygonHelix.dll, PolygonSegments=0, PolygonRadius=1mm, StartHelixRadius=120mm, RadiusChange=2.1mm, Pitch=0mm, Turns=10, SegmentsPerTurn=36, RightHanded=1)
  Box6 = box(corner=(180mm, -160mm, 20mm), size=(40mm, 320mm, -40mm))
  Rx.subtract(Box6)
  Box7 = box(corner=(200mm, -200mm, 160mm), size=(400mm, 600mm, -200mm))
  Rx.subtract(Box7)
  Polyline3 = polyline(xyz in mm: (119.54336, 0, 0) (118.5, -7, 3) (300.5, -7, 3), section circle width=2mm)
  Polyline4 = polyline(z=0mm, xy in mm: (140.46345, 0.0025420426) (141, 9) (300, 9), section circle width=2mm)
  Rx.unite(Polyline3, Polyline4)
  Rx.move(0mm, 0mm, gapdist)
  Rx.move(0mm, misal, 0mm)
  Box8 = box(corner=(200mm, -200mm, 160mm), size=(180mm, 600mm, -200mm))
  Rx.subtract(Box8)
  Box9 = box(corner=(200mm, -200mm, 160mm), size=(220mm, 600mm, -200mm))
  Tx.subtract(Box9)
boundaries and excitations:
  Rx_in: Current Faces=Rx.face(at (200, -7, 103)) Phase=0deg Current=0A IsSolid=true Point_out_of_terminal=false
  Rx_out: Current Faces=Rx.face(at (200, 9, 100)) Phase=0deg Current=0A IsSolid=true Point_out_of_terminal=true
  Tx_in: Current Faces=Tx.face(at (200, -7, 3)) Phase=0deg Current=i IsSolid=false Point_out_of_terminal=false
  Tx_out: Current Faces=Tx.face(at (200, 9, 0)) Phase=0deg Current=i IsSolid=false Point_out_of_terminal=true
parameters:
  Matrix1: Matrix Rx_in, Tx_in:
mesh:
  Region: LengthBased RefineInside Objects=Region MaxLength=100mm
  Ferrite: LengthBased Objects=[Rx_Fer, Tx_Fer] MaxLength=63.245553mm
  Aluminum: LengthBased Objects=[Rx_Al, Tx_Al] MaxLength=72.111026mm
  Coil: LengthBased Objects=[Rx, Tx] MaxLength=68.089342mm
  initial mesh: GlobalSurfApproximation{CurvedSurfaceApproxChoice=UseSlider SliderMeshSettings=1} GlobalCurvilinear{Apply}
setups:
  Setup1: EddyCurrent MaximumPasses=10 MinimumPasses=2 MinimumConvergedPasses=1 PercentRefinement=30 PercentError=10 RelativeResidual=1e-05 NonLinearResidual=0.0001 Frequency=85kHz SweepRanges{80kHz to 100kHz step 1kHz} SaveAllFields
optimetrics:
  ParametricSetup1: Parametric Sim._Setups=[Setup1]
    sweep misal: LIN 0mm 200mm 50mm
field plots:
  ComplexMag_B1: B on Setup1 : LastAdaptive at Freq=85kHz Phase=0deg
  ComplexMag_B2: B in Rx, Tx, Rx_Fer, Tx_Fer, Tx_Al, Rx_Al on Setup1 : LastAdaptive at Freq=85kHz Phase=0deg
reports:
  Coupling Coeff Table 1: Matrix1.CplCoef(Rx_in,Rx_in), Matrix1.CplCoef(Tx_in,Rx_in), Matrix1.CplCoef(Rx_in,Tx_in), Matrix1.CplCoef(Tx_in,Tx_in) vs misal on Setup1 : LastAdaptive [Freq=all]
  Coupling Coeff Plot 1: Matrix1.CplCoef(Tx_in,Rx_in), Matrix1.CplCoef(Rx_in,Tx_in) vs misal on Setup1 : LastAdaptive [Freq=all]
  L Table 1: Matrix1.L(Rx_in,Rx_in), Matrix1.L(Tx_in,Rx_in), Matrix1.L(Rx_in,Tx_in), Matrix1.L(Tx_in,Tx_in) vs misal on Setup1 : LastAdaptive [Freq=all]
  L Plot 1: Matrix1.L(Rx_in,Rx_in), Matrix1.L(Tx_in,Rx_in), Matrix1.L(Rx_in,Tx_in), Matrix1.L(Tx_in,Tx_in) vs misal on Setup1 : LastAdaptive [Freq=all]
  Loss Table 1: CoreLoss vs misal on Setup1 : LastAdaptive [Freq=all]
  Loss Plot 1: CoreLoss vs misal on Setup1 : LastAdaptive [Freq=all]

design Simplorer1 (Twin Builder)
variables:
  V = 220
  R_load = 10ohm
  f = 85kHz
components:
  E_source = E(Type=ESINE EMF=V PERIO=0 AMPL=311.12698V FREQ=f TPERIO=Tend+1)
  Cp = C(C=1.94e-07farad)
  Cs = C(C=9.9e-07farad)
  R1 = R(R=R_load)
  I_in = AM()
  I_out = AM()
  V_in = VM()
  V_out = VM()
  gnd1 = gnd()
  gnd2 = gnd()
  Mx_SS2 = MaxwellData1(ComponentDataType=MaxwellData name=MaxwellData1 filename="$PROJECTDIR\Circular Coil With Ferrite Aluminium.aedt" numberofports=4 CouplingDesignName=Maxwell3DDesign1 CouplingSolutionName="Setup1 : LastAdaptive" CouplingMatrixName=Matrix1 CouplingType=SparamMaxwell3DLink VariationKey="gapdist='100mm' i='5A' misal='0mm'" ModelText='// BEGIN ANSOFT HEADER / // node Rx_in_src Rx_in_src / // node Tx_in_src Tx_in_src / // node Rx_in_snk Rx_in_snk / // node Tx_in_snk Tx_in_snk / // Format: Simplorer SML / // Topckt: MaxwellData1_16 / // Date: Fri Dec 16 11:26:34 2022 / // Notes: Frequency range: 80000 to 92000 Hz, 13 points / // : [Frequency] 8.0000000000000000e+04 / // : [Frequency] 8.1000000000000000e+04 / // : [Frequency] 8.2000000000000000e+04 / // : [Frequency] 8.3000000000000000e+04 / // : [Frequency] 8.4000000000000000e+04 / // : [Frequency] 8.5000000000000000e+04 / // : [Frequency] 8.6000000000000000e+04 / // : [Frequency] 8.7000000000000000e+04 / // : [Frequency] 8.8000000000000000e+04 / // : [Frequency] 8.9000000000000000e+04 / // : [Frequency] 9.0000000000000000e+04 / // : [Frequency] 9.1000000000000000e+04 / // : [Frequency] 9.2000000000000000e+04 / // : Maximum number of poles: 10000 / // : S-Matrix fitting error tolerance: 0.005 / // : Causality check tolerance: 0.01 / // : Passivity enforcement: on (by iterated fitting) / // : Causality enforcement: off / // : Fitting method: FastFit / // : Matrix fitting: By entire matrix (required by FastFit) / // : Ensure Z-paramete)
nets:
  net_1: Cp.0, V_in.0, Mx_SS2.Tx_in_src
  net_10: Cs.0, V_out.0, Mx_SS2.Rx_in_snk
  net_2: Cp.1, I_in.1
  net_3: E_source.0, V_in.1, gnd1.0, Mx_SS2.0
  net_6: R1.0, I_out.1
  net_7: R1.1, V_out.1, gnd2.0, Mx_SS2.Rx_in_src
  net_8: E_source.1, I_in.0
  net_9: I_out.0, Cs.1
setups:
  AC: LinearFrequencyData(1, 80kHz, 100kHz, 1kHz)
optimetrics:
  ParametricSetup1: Parametric SaveSolutions Sim._Setups=[AC]
    sweep Mx_SS2.misal: LIN 0mm 200mm 50mm
reports:
  Data Table 1: (mag(V_out.V)*mag(I_out.I))/(mag(V_in.V)*mag(I_in.I)) vs Mx_SS2.misal on AC : AC [V=all R_load=all f=all Freq=all]
  XY Plot 1: (mag(V_out.V)*mag(I_out.I))/(mag(V_in.V)*mag(I_in.I)) vs Mx_SS2.misal on AC : AC [V=all R_load=all f=all Freq=all]
